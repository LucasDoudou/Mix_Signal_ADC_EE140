ADE simulation setup
Run mode: Single Run, Sweeps and Corners
Tests:
  project_lib_tb_AC_1: project_lib/tb_AC/schematic, simulator spectre
    Variables: vcm = 0.55; vddh = 1.8; vddl = 1.1; vocm = 0.9
    Outputs: CM_Gain; DM_Gain; CMRR; CMRR_at_DC; VDDL_Gain; VDDH_Gain; PSRR_VDDL; PSRR_VDDH; Loop_Gain_Phase; Loop_Gain_dB20; PSRR_VDDL_at_DC; PSRR_VDDH_at_DC; DM_Gain_at_DC
