ADE simulation setup
Test project_lib_tb_AC_1: project_lib/tb_AC/schematic, simulator spectre
  Models: /home/ff/ee140/fa18/gpdk/gpdk045/gpdk045/../models/spectre/gpdk045.scs[mc]
  Variables: vcm = 0.55; vddh = 1.8; vddl = 1.1; vocm = 0.9
  Temperature: 27
  Analysis stb: start=10 stop=1G probe=/IPRB0 stbProbeMode=single-ended
  Analysis ac: start=10 stop=1G dec=10
  Analysis dc: (saves the operating point)
  Output CM_Gain = vfreq('ac "/vcm_out")
  Output DM_Gain = vfreq('ac "/vdm_out")
  Output CMRR = dB20((DM_Gain / CM_Gain))
  Output CMRR_at_DC = value(CMRR 10)
  Output VDDL_Gain = vfreq('ac "/vps_out_vddl")
  Output VDDH_Gain = vfreq('ac "/vps_out_vddh")
  Output PSRR_VDDL = dB20((DM_Gain / VDDL_Gain))
  Output PSRR_VDDH = dB20((DM_Gain / VDDH_Gain))
  Output Loop_Gain_Phase = phaseDegUnwrapped(getData("loopGain" ?result "stb"))
  Output Loop_Gain_dB20 = db(mag(getData("loopGain" ?result "stb")))
  Output Phase Margin = getData("phaseMargin" ?result "stb_margin")
  Output PSRR_VDDL_at_DC = value(PSRR_VDDL 10)
  Output PSRR_VDDH_at_DC = value(PSRR_VDDH 10)
  Output DM_Gain_at_DC = mag(value(DM_Gain 10))
Run mode: Single Run, Sweeps and Corners
