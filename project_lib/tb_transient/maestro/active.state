ADE simulation setup
Test project_lib_tb_transient_1: project_lib/tb_transient/schematic, simulator spectre
  Models: /home/ff/ee140/fa18/gpdk/gpdk045/gpdk045/../models/spectre/gpdk045.scs[mc]
  Variables: vddl = 1.1; vddh = 1.8; vocm = 0.9; vcm = 0.55; vamp = 350m
  Temperature: 27
  Initial conditions: /in_n = vcm; /out_int = vocm; /out_load = vocm
  Analysis tran: stop=22u errpreset=conservative
  Output vout = vtime('tran "/out_int") (unticked)
  Output vout_load = vtime('tran "/out_load")
  Output vin = vtime('tran "/in") (unticked)
  Output vin_n = vtime('tran "/in_n") (unticked)
  Output reset = vtime('tran "/reset") (unticked)
  Output i_vddl = getData("/V1/PLUS" ?result "tran") (unticked)
  Output i_vddh = getData("/V0/PLUS" ?result "tran") (unticked)
  Output avg_pow_vddl = (- ((VAR("vddl") * integ(i_vddl 1.04e-05 1.24e-05 nil)) / 2e-06)) (unticked)
  Output avg_pow_vddh = (- ((VAR("vddh") * integ(i_vddh 1.04e-05 1.24e-05 nil)) / 2e-06)) (unticked)
  Output avg_pow_tot = (avg_pow_vddl + avg_pow_vddh) (unticked)
  Output mid_vout = ((value(vout_load 1.14e-05) + value(vout_load 1.24e-05)) / 2) (unticked)
  Output err_high = clip(abs(((vout_load - (mid_vout + (VAR("vamp") * 2))) / 2 / VAR("vamp"))) 1.04e-05 1.14e-05)
  Output rise_time = (cross(err_high 0.002 -1 "either" nil nil nil) - 1.04e-05) (unticked)
  Output err_low = clip(abs(((vout_load - (mid_vout - (VAR("vamp") * 2))) / 2 / VAR("vamp"))) 1.14e-05 1.24e-05)
  Output fall_time = (cross(err_low 0.002 -1 "either" nil nil nil) - 1.14e-05) (unticked)
  Output settle_time = max(rise_time fall_time)
  Output FoM = (1 / (settle_time * 1000000.0 * avg_pow_tot * 1000.0))
Run mode: Single Run, Sweeps and Corners
Corners (nominal off):
  5mV: vamp=5m
  350mV: vamp=350m
