ADE simulation setup
Run mode: Single Run, Sweeps and Corners
Tests:
  project_lib_tb_transient_1: project_lib/tb_transient/schematic, simulator spectre
    Variables: vcm = 0.55; vamp = 350m; vddl = 1.1; vddh = 1.8; vocm = 0.9
    Outputs: vout; vout_load; vin; vin_n; reset; i_vddl; i_vddh; avg_pow_vddl; avg_pow_vddh; (integ(i_vddl 0 2.4e-06 nil) * VAR("vddl")); mid_vout; (absolute (vout_load - (mid_vout + 0.7))); (absolute (vout_load - (mid_vout + (vamp * 2)))); (abs((vout_load - (mid_vout + (vamp * 2))))); (vout_load - (mid_vout + (vamp * 2))); (vout_load - (mid_vout + (VAR("vamp") * 2))); err_high; rise_time; clip(abs(((vout_load - (mid_vout - (VAR("vamp") * 2))) / VAR("vamp"))) 1.04e-05 1.14e-05); clip(abs(((vout_load - (mid_vout - (VAR("vamp") * 2))) / 4 / VAR("vamp"))) 1.04e-05 1.14e-05); err_low; settle_time; FoM; avg_pow_tot
Corners (nominal off):
  5mV: vamp=5m
  350mV: vamp=350m
